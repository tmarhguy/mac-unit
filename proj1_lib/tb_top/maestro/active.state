ADE simulation setup
Test proj1_lib_tb_top_1: proj1_lib/tb_top/schematic, simulator spectre
  Models: /vast/projects/radway/cad-tools/pdks/gpdk018/cds_ff_mpt/../models/spectre/cds_ff_mpt.scs[tt]
  Variables: cbw = 3.5f; V = 0.8
  Temperature: 27
  Files: vectors /vast/projects/radway/ese-5700-fall/tmarhguy/project_1/stimuli/timing/mac_top_A_2p5ns.vec
  Analysis tran: stop=144n
  Signals: /CLK, /RST, /START, /WE_W, /WE_X, /ACC<11:0>, /DONE
Run mode: Single Run, Sweeps and Corners
