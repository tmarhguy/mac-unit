ADE simulation setup
Run mode: Single Run, Sweeps and Corners
Tests:
  proj1_lib_tb_top_1: proj1_lib/tb_top/schematic, simulator spectre
    Variables: cbw = 3.5f; V = 0.8
