ADE simulation setup
Run mode: Single Run, Sweeps and Corners
Tests:
  proj1_lib_tb_register_1b_1: proj1_lib/tb_register_1b/schematic, simulator spectre
