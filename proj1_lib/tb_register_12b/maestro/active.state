ADE simulation setup
Test proj1_lib_tb_register_12b_1: proj1_lib/tb_register_12b/schematic, simulator spectre
  Models: /vast/projects/radway/cad-tools/pdks/gpdk018/cds_ff_mpt/../models/spectre/cds_ff_mpt.scs[tt]
  Temperature: 27
  Files: vectors /vast/projects/radway/ese-5700-fall/tmarhguy/project_1/stimuli/register_12b.vec
  Analysis tran: stop=18n
  Signals: /CLK, /EN, /RST, /D<11:0>, /Q<11:0>
Run mode: Single Run, Sweeps and Corners
