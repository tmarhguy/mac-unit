ADE simulation setup
Test proj1_lib_tb_controller_1: proj1_lib/tb_controller/schematic, simulator spectre
  Models: /vast/projects/radway/cad-tools/pdks/gpdk018/cds_ff_mpt/../models/spectre/cds_ff_mpt.scs[tt]
  Variables: cwl = 0.5f; tclk = 1n
  Temperature: 27
  Analysis tran: stop=4.5n
  Output wlen_w = (cross(VT("/WL_EN") 0.4 1 "falling") - cross(VT("/WL_EN") 0.4 1 "rising")) (unticked)
  Output t_clk_wl = (cross(VT("/WL<0>") 0.4 1 "rising") - cross(VT("/CLK") 0.4 1 "rising")) (unticked)
  Output gap_pre_wr = (cross(VT("/WR_EN") 0.4 1 "rising") - cross(VT("/PRE_B") 0.4 1 "rising")) (unticked)
  Output t_wl_rden = (cross(VT("/RD_EN") 0.4 1 "rising") - cross(VT("/WL<0>") 0.4 2 "rising")) (unticked)
  Output rden_w = (cross(VT("/RD_EN") 0.4 1 "falling") - cross(VT("/RD_EN") 0.4 1 "rising")) (unticked)
  Output m_wl_pre = (cross(VT("/PRE_B") 0.4 1 "falling") - cross(VT("/WL<0>") 0.4 1 "falling")) (unticked)
  Output m_rd_pre = (cross(VT("/PRE_B") 0.4 2 "falling") - cross(VT("/RD_EN") 0.4 1 "falling")) (unticked)
  Output no_wr_rd = ymax(clip(VT("/WR_EN") 1.5e-09 2.5e-09)) (unticked)
  Output no_rd_wr = ymax(clip(VT("/RD_EN") 5e-10 1.5e-09)) (unticked)
  Signals: /CLK, /WE, /WL_EN, /WR_EN, /RD_EN, /PRE_B, /WL<0>
Run mode: Single Run, Sweeps and Corners
Specs:
  proj1_lib_tb_controller_1 / no_rd_wr: < 0.08
  proj1_lib_tb_controller_1 / no_wr_rd: < 0.08
  proj1_lib_tb_controller_1 / m_wl_pre: > 0
  proj1_lib_tb_controller_1 / m_rd_pre: > 0
  proj1_lib_tb_controller_1 / gap_pre_wr: > 0
