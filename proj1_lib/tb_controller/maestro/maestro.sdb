ADE simulation setup
Run mode: Single Run, Sweeps and Corners
Tests:
  proj1_lib_tb_controller_1: proj1_lib/tb_controller/schematic, simulator spectre
    Variables: cwl = 0.5f; tclk = 1n
    Outputs: wlen_w; t_clk_wl; gap_pre_wr; t_wl_rden; rden_w; m_wl_pre; m_rd_pre; no_wr_rd; no_rd_wr
Specs:
  proj1_lib_tb_controller_1 / no_rd_wr: < 0.08
  proj1_lib_tb_controller_1 / no_wr_rd: < 0.08
  proj1_lib_tb_controller_1 / m_wl_pre: > 0
  proj1_lib_tb_controller_1 / m_rd_pre: > 0
  proj1_lib_tb_controller_1 / gap_pre_wr: > 0
