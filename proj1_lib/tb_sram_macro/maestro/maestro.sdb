ADE simulation setup
Run mode: Single Run, Sweeps and Corners
Tests:
  proj1_lib_tb_sram_macro_1: proj1_lib/tb_sram_macro/schematic, simulator spectre
    Variables: cbw = 0.62f; tclk = 0.7n 0.69n 0.68n 0.67n 0.66n 0.65n 0.6n
    Outputs: err1; err2; t_acc_f; t_acc_r
