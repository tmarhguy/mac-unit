ADE simulation setup
Test proj1_lib_6t_sram_read_snm_tb_1: proj1_lib/6t_sram_read_snm_tb/schematic, simulator spectre
  Models: /vast/projects/radway/cad-tools/pdks/gpdk018/cds_ff_mpt/../models/spectre/cds_ff_mpt.scs[tt]
  Variables: VQSWEEP = 0
  Temperature: 27
  Analysis dc: sweep VQSWEEP start=0 stop=0.8 step=0.001
  Signals: /QB_OUT
Run mode: Single Run, Sweeps and Corners
