ADE simulation setup
Test proj1_lib_tb_accumulator_12b_1: proj1_lib/tb_accumulator_12b/schematic, simulator spectre
  Models: /vast/projects/radway/cad-tools/pdks/gpdk018/cds_ff_mpt/../models/spectre/cds_ff_mpt.scs[tt]
  Temperature: 27
  Analysis tran: stop=24n
  Signals: /ACC<11:0>
Run mode: Single Run, Sweeps and Corners
