ADE simulation setup
Test proj1_lib_tb_accumulator_12b_1: proj1_lib/tb_accumulator_12b/schematic, simulator spectre
  Models: /vast/projects/radway/cad-tools/pdks/gpdk018/cds_ff_mpt/../models/spectre/cds_ff_mpt.scs[tt]
  Temperature: 27
  Files: vectors /vast/projects/radway/ese-5700-fall/tmarhguy/project_1/stimuli/accumulator_12b.vec
  Analysis tran: stop=106n
  Signals: /ACC<11:0>, /CLK, /EN, /RST, /PROD<7:0>
Run mode: Single Run, Sweeps and Corners
