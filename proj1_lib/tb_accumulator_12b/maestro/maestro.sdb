ADE simulation setup
Run mode: Single Run, Sweeps and Corners
Tests:
  proj1_lib_tb_accumulator_12b_1: proj1_lib/tb_accumulator_12b/schematic, simulator spectre
    Outputs: "/RST"
