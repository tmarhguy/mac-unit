* +++++++++++++++++++++++++++++++++++++++++++++++++++++++++ *
* CDL Netlist:                                              *
*                                                           *
* Cell Name  : sram_6t                                      *
* Netlisted  : Sun Oct 18 19:14:39 2026                     *
* Pegasus Version: 23.20-p013 Tue Jan 9 12:32:47 PST 2024   *
* +++++++++++++++++++++++++++++++++++++++++++++++++++++++++ *
*.LDD
*.DEVTMPLT 0 R(resm1) m1res_dev m1_conn_mask1(PLUS) m1_conn_mask1(MINUS)
*.DEVTMPLT 1 R(resm1) m1res_dev m1_conn_mask2(PLUS) m1_conn_mask2(MINUS)
*.DEVTMPLT 2 R(resm2) m2res_dev m2_conn_mask1(PLUS) m2_conn_mask1(MINUS)
*.DEVTMPLT 3 R(resm2) m2res_dev m2_conn_mask2(PLUS) m2_conn_mask2(MINUS)
*.DEVTMPLT 4 R(resm3) m3res_dev m3_conn_mask1(PLUS) m3_conn_mask1(MINUS)
*.DEVTMPLT 5 R(resm3) m3res_dev m3_conn_mask2(PLUS) m3_conn_mask2(MINUS)
*.DEVTMPLT 6 R(resm4) m4res_dev m4_conn(PLUS) m4_conn(MINUS)
*.DEVTMPLT 7 R(resm5) m5res_dev m5_conn(PLUS) m5_conn(MINUS)
*.DEVTMPLT 8 R(resm6) m6res_dev m6_conn(PLUS) m6_conn(MINUS)
*.DEVTMPLT 9 R(resm7) m7res_dev m7_conn(PLUS) m7_conn(MINUS)
*.DEVTMPLT 10 R(resmt) mtres_dev mt_conn(PLUS) mt_conn(MINUS)
*.DEVTMPLT 11 R(rsnp) rsnp_dev npoly_conn(PLUS) npoly_conn(MINUS)
*.DEVTMPLT 12 R(rsnp) rsnp_dev ppoly_conn(PLUS) ppoly_conn(MINUS)
*.DEVTMPLT 13 R(rnsnp) rnsnp_dev npoly_conn(PLUS) npoly_conn(MINUS)
*.DEVTMPLT 14 R(rnsnp) rnsnp_dev ppoly_conn(PLUS) ppoly_conn(MINUS)
*.DEVTMPLT 15 R(rspp) rspp_dev ppoly_conn(PLUS) ppoly_conn(MINUS)
*.DEVTMPLT 16 R(rspp) rspp_dev npoly_conn(PLUS) npoly_conn(MINUS)
*.DEVTMPLT 17 R(rnspp) rnspp_dev ppoly_conn(PLUS) ppoly_conn(MINUS)
*.DEVTMPLT 18 R(rnspp) rnspp_dev npoly_conn(PLUS) npoly_conn(MINUS)
*.DEVTMPLT 19 R(rnsnd) rnsnd_dev ndiffres_term(PLUS) ndiffres_term(MINUS)
*.DEVTMPLT 20 R(rsnd) rsnd_dev ndiffres_term(PLUS) ndiffres_term(MINUS)
*.DEVTMPLT 21 R(rnspd) rnspd_dev pdiffres_term(PLUS) pdiffres_term(MINUS)
*.DEVTMPLT 22 R(rspd) rspd_dev pdiffres_term(PLUS) pdiffres_term(MINUS)
*.DEVTMPLT 23 R(rnwo) rnwo_dev nw_term(PLUS) nw_term(MINUS)
*.DEVTMPLT 24 R(rnws) rnws_dev nw_term(PLUS) nw_term(MINUS)
*.DEVTMPLT 25 C(cmim) mim_cap_dev CMT(PLUS) m7_conn(MINUS)
*.DEVTMPLT 26 Q(npn) npn_dev_1x1 BuriedNWell(C) iso_pwell(B) npn_emit(E) psub(S)
*.DEVTMPLT 27 Q(npn) npn_dev_2x2 BuriedNWell(C) iso_pwell(B) npn_emit(E) psub(S)
*.DEVTMPLT 28 D(nd1hvt) nd1hvt_dev psub(PLUS) ndiff_conn(MINUS)
*.DEVTMPLT 29 D(nd1lvt) nd1lvt_dev psub(PLUS) ndiff_conn(MINUS)
*.DEVTMPLT 30 D(nd1svt) nd1svt_dev psub(PLUS) ndiff_conn(MINUS)
*.DEVTMPLT 31 D(nd2svt) nd2svt_dev psub(PLUS) ndiff_conn(MINUS)
*.DEVTMPLT 32 D(pd1hvt) pd1hvt_dev pdiff_conn(PLUS) nw_conn(MINUS)
*.DEVTMPLT 33 D(pd1lvt) pd1lvt_dev pdiff_conn(PLUS) nw_conn(MINUS)
*.DEVTMPLT 34 D(pd1svt) pd1svt_dev pdiff_conn(PLUS) nw_conn(MINUS)
*.DEVTMPLT 35 D(pd2svt) pd2svt_dev pdiff_conn(PLUS) nw_conn(MINUS)
*.DEVTMPLT 36 MN(n1hvt) n1hvt_dev nsd(D) ngate(G) nsd(S) psub(B)
*.DEVTMPLT 37 MN(n1hvt) n1hvt_dev_iso nsd(D) ngate(G) nsd(S) iso_pwell(B)
*.DEVTMPLT 38 MN(n1lvt) n1lvt_dev nsd(D) ngate(G) nsd(S) psub(B)
*.DEVTMPLT 39 MN(n1lvt) n1lvt_dev_iso nsd(D) ngate(G) nsd(S) iso_pwell(B)
*.DEVTMPLT 40 MN(n1svt) n1svt_dev nsd(D) ngate(G) nsd(S) psub(B)
*.DEVTMPLT 41 MN(n1svt) n1svt_dev_iso nsd(D) ngate(G) nsd(S) iso_pwell(B)
*.DEVTMPLT 42 MN(n2svt) n2svt_dev nsd(D) ngate(G) nsd(S) psub(B)
*.DEVTMPLT 43 MN(n2svt) n2svt_dev_iso nsd(D) ngate(G) nsd(S) iso_pwell(B)
*.DEVTMPLT 44 MP(p1hvt) p1hvt_dev psd(D) pgate(G) psd(S) nw_conn(B)
*.DEVTMPLT 45 MP(p1lvt) p1lvt_dev psd(D) pgate(G) psd(S) nw_conn(B)
*.DEVTMPLT 46 MP(p1svt) p1svt_dev psd(D) pgate(G) psd(S) nw_conn(B)
*.DEVTMPLT 47 MP(p2svt) p2svt_dev psd(D) pgate(G) psd(S) nw_conn(B)

* +++++++++++++++++++++++++++++++++++++++++++++++++++++++++ *
* Sub cell: p1svt_CDNS_792365268070                         *
* +++++++++++++++++++++++++++++++++++++++++++++++++++++++++ *
.subckt p1svt_CDNS_792365268070 1 2 3
** N=12 EP=3 FDC=1
M0 3 1 2 2 p1svt L=1.8e-08 nf=1 nfin=2 asej=1.904e-15 adej=1.904e-15 psej=3e-07 pdej=3e-07 $X=0 $Y=0 $dt=46
.ends p1svt_CDNS_792365268070

* +++++++++++++++++++++++++++++++++++++++++++++++++++++++++ *
* Sub cell: n1svt_CDNS_792365268071                         *
* +++++++++++++++++++++++++++++++++++++++++++++++++++++++++ *
.subckt n1svt_CDNS_792365268071 1 2 3 4
** N=12 EP=4 FDC=1
M0 3 1 2 4 n1svt L=1.8e-08 nf=1 nfin=2 asej=1.904e-15 adej=1.904e-15 psej=3e-07 pdej=3e-07 $X=0 $Y=0 $dt=40
.ends n1svt_CDNS_792365268071

* +++++++++++++++++++++++++++++++++++++++++++++++++++++++++ *
* Sub cell: n1svt_CDNS_792365268072                         *
* +++++++++++++++++++++++++++++++++++++++++++++++++++++++++ *
.subckt n1svt_CDNS_792365268072 1 2 3
** N=11 EP=3 FDC=1
M0 3 1 2 2 n1svt L=1.8e-08 nf=1 nfin=4 asej=3.808e-15 adej=3.808e-15 psej=6e-07 pdej=6e-07 $X=0 $Y=0 $dt=40
.ends n1svt_CDNS_792365268072

* +++++++++++++++++++++++++++++++++++++++++++++++++++++++++ *
* Sub cell: n1svt_CDNS_792365268075                         *
* +++++++++++++++++++++++++++++++++++++++++++++++++++++++++ *
.subckt n1svt_CDNS_792365268075 1 2 3
** N=11 EP=3 FDC=1
M0 3 1 2 2 n1svt L=1.8e-08 nf=1 nfin=4 asej=3.808e-15 adej=3.808e-15 psej=6e-07 pdej=6e-07 $X=0 $Y=0 $dt=40
.ends n1svt_CDNS_792365268075

* +++++++++++++++++++++++++++++++++++++++++++++++++++++++++ *
* Sub cell: sram_6t                                         *
* +++++++++++++++++++++++++++++++++++++++++++++++++++++++++ *
.subckt sram_6t BL BLB Q QB VDD VSS WL
** N=7 EP=7 FDC=6
X66 QB VDD Q p1svt_CDNS_792365268070 $T=5000 4000 0 0 $X=4484 $Y=3870
X67 Q VDD QB p1svt_CDNS_792365268070 $T=5000 7000 0 0 $X=4484 $Y=6870
X68 WL BL Q VSS n1svt_CDNS_792365268071 $T=5000 16000 0 0 $X=4484 $Y=15904
X69 WL QB BLB VSS n1svt_CDNS_792365268071 $T=5000 19000 0 0 $X=4484 $Y=18904
X70 Q VSS QB n1svt_CDNS_792365268072 $T=5000 13000 0 0 $X=4484 $Y=12904
X73 QB VSS Q n1svt_CDNS_792365268075 $T=5000 10000 0 0 $X=4484 $Y=9904
.ends sram_6t
