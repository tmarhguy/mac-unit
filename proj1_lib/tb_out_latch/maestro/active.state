ADE simulation setup
Test proj1_lib_tb_out_latch_1: proj1_lib/tb_out_latch/schematic, simulator spectre
  Models: /vast/projects/radway/cad-tools/pdks/gpdk018/cds_ff_mpt/../models/spectre/cds_ff_mpt.scs[tt]
  Variables: cdout = 1f; pw_en = 150p
  Temperature: 27
  Analysis tran: stop=4.2n errpreset=moderate
  Output t_en_r = (cross(clip(VT("/DOUT") 1.2e-09 2e-09) 0.4 1 "rising") - cross(clip(VT("/EN") 1.2e-09 2e-09) 0.4 1 "rising"))
  Output t_en_f = (cross(clip(VT("/DOUT") 2.2e-09 3e-09) 0.4 1 "falling") - cross(clip(VT("/EN") 2.2e-09 3e-09) 0.4 1 "rising"))
  Output hold1 = ymin(clip(VT("/DOUT") 1.5e-09 2.29e-09))
  Output hold0 = ymax(clip(VT("/DOUT") 2.5e-09 3.29e-09))
  Signals: /RD, /EN, /DOUT
Run mode: Single Run, Sweeps and Corners
Specs:
  proj1_lib_tb_out_latch_1 / hold1: > 0.72
  proj1_lib_tb_out_latch_1 / hold0: < 0.08
Setup values for test proj1_lib_tb_out_latch_1: pw_en = 10p 20p 40p 80p 150p
