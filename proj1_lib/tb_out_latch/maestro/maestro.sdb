ADE simulation setup
Run mode: Single Run, Sweeps and Corners
Tests:
  proj1_lib_tb_out_latch_1: proj1_lib/tb_out_latch/schematic, simulator spectre
    Variables: cdout = 1f; pw_en = 10p 20p 40p 80p 150p
    Outputs: t_en_r; t_en_f; hold1; hold0
Specs:
  proj1_lib_tb_out_latch_1 / hold1: > 0.72
  proj1_lib_tb_out_latch_1 / hold0: < 0.08
