ADE simulation setup
Test proj1_lib_tb_fulladder_12b_1: proj1_lib/tb_fulladder_12b/schematic, simulator spectre
  Models: /vast/projects/radway/cad-tools/pdks/gpdk018/cds_ff_mpt/../models/spectre/cds_ff_mpt.scs[tt]
  Temperature: 27
  Files: vectors /vast/projects/radway/ese-5700-fall/tmarhguy/project_1/stimuli/fulladder_12b.vec
  Analysis tran: stop=36n
  Signals: /COUT, /S<11:0>, /A<11:0>, /B<11:0>, /CIN
Run mode: Single Run, Sweeps and Corners
