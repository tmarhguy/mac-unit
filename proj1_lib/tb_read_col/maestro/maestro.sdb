ADE simulation setup
Run mode: Single Run, Sweeps and Corners
Tests:
  proj1_lib_tb_read_col_1: proj1_lib/tb_read_col/schematic, simulator spectre
    Variables: CBL = 3.5f; cdout = 1f; pw_w1 = 120p; rd_dly = 1.48n; pw_rden = 120p
    Outputs: t_acc1; t_acc0; t_rd; dout_c2; dout_c4; dout_c6; q_rd1; q_rd0; t_blb; dout_g2
Global variables:
  pw_w1 = 40p 60p 80p 100p 120p 150p
  CBL = 3.5f 4.2f
Specs:
  proj1_lib_tb_read_col_1 / dout_c2: > 0.72
  proj1_lib_tb_read_col_1 / dout_c4: < 0.08
  proj1_lib_tb_read_col_1 / dout_c6: > 0.72
  proj1_lib_tb_read_col_1 / q_rd1: > 0.72
  proj1_lib_tb_read_col_1 / q_rd0: < 0.08
  proj1_lib_tb_read_col_1 / dout_g2: > 0.72
