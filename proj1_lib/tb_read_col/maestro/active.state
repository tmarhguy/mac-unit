ADE simulation setup
Test proj1_lib_tb_read_col_1: proj1_lib/tb_read_col/schematic, simulator spectre
  Models: /vast/projects/radway/cad-tools/pdks/gpdk018/cds_ff_mpt/../models/spectre/cds_ff_mpt.scs[tt]
  Variables: pw_rden = 120p ; CBL = 3.5f; cdout = 1f; pw_w1 = 120p; rd_dly = 1.48n
  Temperature: 27
  Analysis tran: stop=6n errpreset=moderate
  Output t_acc1 = (cross(clip(VT("/DOUT") 5.3e-09 6e-09) 0.4 1 "rising") - cross(clip(VT("/WL") 5.3e-09 6e-09) 0.4 1 "rising"))
  Output t_acc0 = (cross(clip(VT("/DOUT") 3.3e-09 4e-09) 0.4 1 "falling") - cross(clip(VT("/WL") 3.3e-09 4e-09) 0.4 1 "rising"))
  Output t_rd = (cross(clip(VT("/RD") 5.3e-09 6e-09) 0.4 1 "rising") - cross(clip(VT("/WL") 5.3e-09 6e-09) 0.4 1 "rising"))
  Output dout_c2 = value(VT("/DOUT") 2.9e-09)
  Output dout_c4 = value(VT("/DOUT") 4.9e-09)
  Output dout_c6 = value(VT("/DOUT") 5.9e-09)
  Output q_rd1 = value(VT("/Q") 1.95e-09)
  Output q_rd0 = value(VT("/Q") 3.95e-09)
  Output t_blb = (cross(clip(VT("/BLB") 5.3e-09 6e-09) 0.376 1 "falling") - cross(clip(VT("/WL") 5.3e-09 6e-09) 0.4 1 "rising"))
  Output dout_g2 = ymin(clip(VT("/DOUT") 1.4e-09 2e-09))
  Signals: /WL, /BLB, /RD, /RD_EN, /DOUT, /Q, /QB
Run mode: Single Run, Sweeps and Corners
Global variables:
  pw_w1 = 40p 60p 80p 100p 120p 150p
  CBL = 3.5f 4.2f
Specs:
  proj1_lib_tb_read_col_1 / dout_c2: > 0.72
  proj1_lib_tb_read_col_1 / dout_c4: < 0.08
  proj1_lib_tb_read_col_1 / dout_c6: > 0.72
  proj1_lib_tb_read_col_1 / q_rd1: > 0.72
  proj1_lib_tb_read_col_1 / q_rd0: < 0.08
  proj1_lib_tb_read_col_1 / dout_g2: > 0.72
Setup values for test proj1_lib_tb_read_col_1: pw_rden = 120p
Disabled tests: proj1_lib_tb_write_driver_1
