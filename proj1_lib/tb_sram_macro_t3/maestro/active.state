ADE simulation setup
Test proj1_lib_tb_sram_macro_t3_1: proj1_lib/tb_sram_macro_t3/schematic, simulator spectre
  Models: /vast/projects/radway/cad-tools/pdks/gpdk018/cds_ff_mpt/../models/spectre/cds_ff_mpt.scs[tt]
  Temperature: 27
Test proj1_lib_tb_sram_macro_1: proj1_lib/tb_sram_macro_t3/schematic, simulator spectre
  Models: /vast/projects/radway/cad-tools/pdks/gpdk018/cds_ff_mpt/../models/spectre/cds_ff_mpt.scs[tt]
  Variables: cbw = 0.62f; tclk = 1n
  Temperature: 27
  Analysis tran: stop=22n errpreset=moderate
  Output err3 = ymax(clip((VT("/M") * (abs((VT("/DOUT<0>") - VT("/E"))) + abs((VT("/DOUT<1>") - (0.8 - VT("/E")))) + abs((VT("/DOUT<2>") - VT("/E"))) + abs((VT("/DOUT<3>") - (0.8 - VT("/E")))))) (2 * VAR("tclk")) (20 * VAR("tclk"))))
  Output t_wr1 = (max(cross(clip(VT("/I0/COL<0>/Q<15>") (2.4 * VAR("tclk")) (3.4 * VAR("tclk"))) 0.335 1 "rising") cross(clip(VT("/I0/COL<0>/QB<15>") (2.4 * VAR("tclk")) (3.4 * VAR("tclk"))) 0.335 1 "falling")) - cross(clip(VT("/CLK") (2.4 * VAR("tclk")) (3.4 * VAR("tclk"))) 0.4 1 "rising"))
  Output t_wr0 = (max(cross(clip(VT("/I0/COL<0>/Q<15>") (4.4 * VAR("tclk")) (5.4 * VAR("tclk"))) 0.335 1 "falling") cross(clip(VT("/I0/COL<0>/QB<15>") (4.4 * VAR("tclk")) (5.4 * VAR("tclk"))) 0.335 1 "rising")) - cross(clip(VT("/CLK") (4.4 * VAR("tclk")) (5.4 * VAR("tclk"))) 0.4 1 "rising"))
  Output t_acc1 = (cross(clip(VT("/DOUT<0>") (3.4 * VAR("tclk")) (4.5 * VAR("tclk"))) 0.4 1 "rising") - cross(clip(VT("/CLK") (3.4 * VAR("tclk")) (4.5 * VAR("tclk"))) 0.4 1 "rising"))
  Output t_acc0 = (cross(clip(VT("/DOUT<0>") (5.4 * VAR("tclk")) (6.5 * VAR("tclk"))) 0.4 1 "falling") - cross(clip(VT("/CLK") (5.4 * VAR("tclk")) (6.5 * VAR("tclk"))) 0.4 1 "rising"))
  Output err3_wave = (VT("/M") * (abs((VT("/DOUT<0>") - VT("/E"))) + abs((VT("/DOUT<1>") - (0.8 - VT("/E")))) + abs((VT("/DOUT<2>") - VT("/E"))) + abs((VT("/DOUT<3>") - (0.8 - VT("/E"))))))
  Signals: /CLK, /WE, /ADDR<3>, /ADDR<2>, /ADDR<1>, /ADDR<0>, /DIN<3>, /DIN<2>, /DIN<1>, /DIN<0>, /DOUT<3>, /DOUT<2>, /DOUT<1>, /DOUT<0>, /M, /E, /I0/COL<0>/Q<15:0>, /I0/COL<0>/QB<15:0>, /I0/WL<15:0>, /I0/COL<0>/BLB, /I0/COL<0>/RD, /I0/PRE_B, /I0/VDD (terminal), /I0/RD_EN
Run mode: Single Run, Sweeps and Corners
Global variables:
  cbw = 0.62f
  tclk = 0.7n 1n
Specs:
  proj1_lib_tb_sram_macro_1 / err3: < 0.1
Setup values for test proj1_lib_tb_sram_macro_1: tclk = 0.69n 0.68n
Disabled tests: proj1_lib_tb_sram_macro_1
