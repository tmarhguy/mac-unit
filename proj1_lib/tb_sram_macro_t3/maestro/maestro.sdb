ADE simulation setup
Run mode: Single Run, Sweeps and Corners
Tests:
  proj1_lib_tb_sram_macro_1 (off): proj1_lib/tb_sram_macro_t3/schematic, simulator spectre
    Variables: cbw = 0.62f; tclk = 0.69n 0.68n
    Outputs: t_wr1; t_wr0; err3; /I0/WL<15:0>; /I0/COL<0>/BLB; /I0/COL<0>/BL; "/I0/COL<0>/RD"; "/I0/PRE_B"; /I0/PRE_B; t_acc1; t_acc0; /I0/COL<0>/RD; /I0/RD_EN; err3_wave
  proj1_lib_tb_sram_macro_t3_1: proj1_lib/tb_sram_macro_t3/schematic, simulator spectre
Global variables:
  cbw = 0.62f
  tclk = 0.7n 1n
Specs:
  proj1_lib_tb_sram_macro_1 / err3: < 0.1
