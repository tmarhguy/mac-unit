ADE simulation setup
Run mode: Single Run, Sweeps and Corners
Tests:
  proj1_lib_mux2_1: proj1_lib/mux2/schematic, simulator spectre
