ADE simulation setup
Run mode: Single Run, Sweeps and Corners
Tests:
  proj1_lib_top_1: proj1_lib/top/schematic, simulator spectre
    Variables: cbw = 3.5fF
