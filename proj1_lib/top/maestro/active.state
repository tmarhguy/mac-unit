ADE simulation setup
Test proj1_lib_top_1: proj1_lib/top/schematic, simulator spectre
  Models: /vast/projects/radway/cad-tools/pdks/gpdk018/cds_ff_mpt/../models/spectre/cds_ff_mpt.scs[tt]
  Variables: cbw = 3.5fF
  Temperature: 27
  Analysis tran: stop=10m
Run mode: Single Run, Sweeps and Corners
