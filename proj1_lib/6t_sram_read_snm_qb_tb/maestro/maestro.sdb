ADE simulation setup
Run mode: Single Run, Sweeps and Corners
Tests:
  proj1_lib_6t_sram_read_snm_qb_tb_1: proj1_lib/6t_sram_read_snm_qb_tb/schematic, simulator spectre
    Variables: VQSWEEP = 0
