ADE simulation setup
Test proj1_lib_6t_sram_read_snm_qb_tb_1: proj1_lib/6t_sram_read_snm_qb_tb/schematic, simulator spectre
  Models: /vast/projects/radway/cad-tools/pdks/gpdk018/cds_ff_mpt/../models/spectre/cds_ff_mpt.scs[tt]
  Variables: VQSWEEP = 0
  Temperature: 27
  Analysis dc: sweep VQSWEEP start=0 stop=0.8 step=0.001
  Signals: /Q_OUT, /qb_vqsweep
Run mode: Single Run, Sweeps and Corners
