ADE simulation setup
Test proj1_lib_xor2_1: proj1_lib/xor2/schematic, simulator spectre
  Models: /vast/projects/radway/cad-tools/pdks/gpdk018/cds_ff_mpt/../models/spectre/cds_ff_mpt.scs[tt]
  Temperature: 27
Run mode: Single Run, Sweeps and Corners
