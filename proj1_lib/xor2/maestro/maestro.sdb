ADE simulation setup
Run mode: Single Run, Sweeps and Corners
Tests:
  proj1_lib_xor2_1: proj1_lib/xor2/schematic, simulator spectre
