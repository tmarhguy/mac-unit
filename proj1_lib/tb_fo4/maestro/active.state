ADE simulation setup
Test proj1_lib_tb_fo4_1: proj1_lib/tb_fo4/schematic, simulator spectre
  Models: /vast/projects/radway/cad-tools/pdks/gpdk018/cds_ff_mpt/../models/spectre/cds_ff_mpt.scs[tt]
  Temperature: 27
  Analysis tran: stop=1.2n
  Output tphl = (cross(VT("/N2") 0.4 1 "falling") - cross(VT("/N1") 0.4 1 "rising"))
  Output tplh = (cross(VT("/N2") 0.4 1 "rising") - cross(VT("/N1") 0.4 1 "falling"))
  Signals: /IN, /N1, /N2
Run mode: Single Run, Sweeps and Corners
