ADE simulation setup
Run mode: Single Run, Sweeps and Corners
Tests:
  proj1_lib_tb_fo4_1: proj1_lib/tb_fo4/schematic, simulator spectre
    Outputs: tphl; tplh
