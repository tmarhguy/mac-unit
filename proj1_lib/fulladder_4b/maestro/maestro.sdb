ADE simulation setup
Run mode: Single Run, Sweeps and Corners
Tests:
  proj1_lib_fulladder_4b_1: proj1_lib/fulladder_4b/schematic, simulator spectre
