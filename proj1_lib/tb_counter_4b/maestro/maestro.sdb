ADE simulation setup
Run mode: Single Run, Sweeps and Corners
Tests:
  proj1_lib_tb_counter_4b_1: proj1_lib/tb_counter_4b/schematic, simulator spectre
    Variables: vdd = 0.8
    Outputs: /I1/D0; /I1/I5/net5
