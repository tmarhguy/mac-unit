ADE simulation setup
Test proj1_lib_tb_counter_4b_1: proj1_lib/tb_counter_4b/schematic, simulator spectre
  Models: /vast/projects/radway/cad-tools/pdks/gpdk018/cds_ff_mpt/../models/spectre/cds_ff_mpt.scs[tt]
  Variables: vdd = 0.8
  Temperature: 27
  Files: vectors /vast/home/v/vwanjohi/simulation/stimuli/counter4b.vec
  Analysis tran: stop=39n
  Signals: /CLK, /EN, /COUNT<3:0>, /I1/D0, /I1/I5/net5, /VDD
Run mode: Single Run, Sweeps and Corners
