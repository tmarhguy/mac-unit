ADE simulation setup
Test proj1_lib_tb_dec_pre_1: proj1_lib/tb_dec_pre/schematic_old, simulator spectre
  Models: /vast/projects/radway/cad-tools/pdks/gpdk018/cds_ff_mpt/../models/spectre/cds_ff_mpt.scs[tt]
  Variables: a0 = 0; a1 = 0 ; a2 = 0 ; a3 = 0 ; cwl = 0.5f
  Temperature: 27
  Analysis tran: stop=4n
  Output t_en_r = (cross((VT("/WL<0>") + VT("/WL<1>") + VT("/WL<2>") + VT("/WL<3>") + VT("/WL<4>") + VT("/WL<5>") + VT("/WL<6>") + VT("/WL<7>") + VT("/WL<8>") + VT("/WL<9>") + VT("/WL<10>") + VT("/WL<11>") + VT("/WL<12>") + VT("/WL<13>") + VT("/WL<14>") + VT("/WL<15>")) 0.4 1 "rising") - cross(VT("/WL_EN") 0.4 1 "rising"))
  Output t_en_f = (cross((VT("/WL<0>") + VT("/WL<1>") + VT("/WL<2>") + VT("/WL<3>") + VT("/WL<4>") + VT("/WL<5>") + VT("/WL<6>") + VT("/WL<7>") + VT("/WL<8>") + VT("/WL<9>") + VT("/WL<10>") + VT("/WL<11>") + VT("/WL<12>") + VT("/WL<13>") + VT("/WL<14>") + VT("/WL<15>")) 0.4 1 "falling") - cross(VT("/WL_EN") 0.4 1 "falling"))
  Output wl_one = ymax((VT("/WL<0>") + VT("/WL<1>") + VT("/WL<2>") + VT("/WL<3>") + VT("/WL<4>") + VT("/WL<5>") + VT("/WL<6>") + VT("/WL<7>") + VT("/WL<8>") + VT("/WL<9>") + VT("/WL<10>") + VT("/WL<11>") + VT("/WL<12>") + VT("/WL<13>") + VT("/WL<14>") + VT("/WL<15>")))
  Output wl_hi = ymax((VT("/WL<0>") + VT("/WL<1>") + VT("/WL<2>") + VT("/WL<3>") + VT("/WL<4>") + VT("/WL<5>") + VT("/WL<6>") + VT("/WL<7>") + VT("/WL<8>") + VT("/WL<9>") + VT("/WL<10>") + VT("/WL<11>") + VT("/WL<12>") + VT("/WL<13>") + VT("/WL<14>") + VT("/WL<15>")))
  Output wl_idx = ((ymax(VT("/WL<1>")) + (2 * ymax(VT("/WL<2>"))) + (3 * ymax(VT("/WL<3>"))) + (4 * ymax(VT("/WL<4>"))) + (5 * ymax(VT("/WL<5>"))) + (6 * ymax(VT("/WL<6>"))) + (7 * ymax(VT("/WL<7>"))) + (8 * ymax(VT("/WL<8>"))) + (9 * ymax(VT("/WL<9>"))) + (10 * ymax(VT("/WL<10>"))) + (11 * ymax(VT("/WL<11>"))) + (12 * ymax(VT("/WL<12>"))) + (13 * ymax(VT("/WL<13>"))) + (14 * ymax(VT("/WL<14>"))) + (15 * ymax(VT("/WL<15>")))) / 0.824)
  Output t_ar = (cross(VT("/WL<1>") 0.4 1 "rising") - cross(VT("/A<0>") 0.4 1 "rising"))
  Output t_af = (cross(VT("/WL<0>") 0.4 1 "falling") - cross(VT("/A<0>") 0.4 1 "rising"))
  Output t_br = (cross(VT("/WL<0>") 0.4 1 "rising") - cross(VT("/A<0>") 0.4 1 "falling"))
  Output t_bf = (cross(VT("/WL<1>") 0.4 1 "falling") - cross(VT("/A<0>") 0.4 1 "falling"))
  Signals: /WL_EN, /WL<15>, /WL<14>, /WL<13>, /WL<12>, /WL<11>, /WL<10>, /WL<9>, /WL<8>, /WL<7>, /WL<6>, /WL<5>, /WL<4>, /WL<3>, /WL<2>, /WL<1>, /WL<0>, /A<0>
Run mode: Single Run, Sweeps and Corners
Specs:
  proj1_lib_tb_dec_pre_1 / wl_one: < 1
  proj1_lib_tb_dec_pre_1 / wl_hi: > 0.72
Setup values for test proj1_lib_tb_dec_pre_1: a0 = 0 0.8; a1 = 0 0.8; a2 = 0 0.8; a3 = 0 0.8
