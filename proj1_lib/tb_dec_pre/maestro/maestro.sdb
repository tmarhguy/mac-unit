ADE simulation setup
Run mode: Single Run, Sweeps and Corners
Tests:
  proj1_lib_tb_dec_pre_1: proj1_lib/tb_dec_pre/schematic_old, simulator spectre
    Variables: a0 = 0 0.8; a1 = 0 0.8; a2 = 0 0.8; a3 = 0 0.8; cwl = 0.5f
    Outputs: t_en_r; t_en_f; wl_hi; wl_one; wl_idx
Specs:
  proj1_lib_tb_dec_pre_1 / wl_one: < 1
  proj1_lib_tb_dec_pre_1 / wl_hi: > 0.72
