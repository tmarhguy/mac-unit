ADE simulation setup
Test proj1_lib_tb_multiplier4b_1: proj1_lib/tb_multiplier4b/schematic, simulator spectre
  Models: /vast/projects/radway/cad-tools/pdks/gpdk018/cds_ff_mpt/../models/spectre/cds_ff_mpt.scs[tt]
  Variables: tv = 1n; vdd = 0.8
  Temperature: 27
  Analysis tran: stop=256*VAR("tv") errpreset=conservative
  Output errmax_old = ymax(sample((abs(((VT("/P<0>") + (2 * VT("/P<1>")) + (4 * VT("/P<2>")) + (8 * VT("/P<3>")) + (16 * VT("/P<4>")) + (32 * VT("/P<5>")) + (64 * VT("/P<6>")) + (128 * VT("/P<7>"))) - (((VT("/A<0>") + (2 * VT("/A<1>")) + (4 * VT("/A<2>")) + (8 * VT("/A<3>"))) * (VT("/B<0>") + (2 * VT("/B<1>")) + (4 * VT("/B<2>")) + (8 * VT("/B<3>")))) / 0.8))) / 0.8) 9e-10 2.559e-07 "linear" 1e-09))
  Output Pint = ((VT("/P<0>") + (2 * VT("/P<1>")) + (4 * VT("/P<2>")) + (8 * VT("/P<3>")) + (16 * VT("/P<4>")) + (32 * VT("/P<5>")) + (64 * VT("/P<6>")) + (128 * VT("/P<7>"))) / 0.8)
  Output ABint = (((VT("/A<0>") + (2 * VT("/A<1>")) + (4 * VT("/A<2>")) + (8 * VT("/A<3>"))) / 0.8) * ((VT("/B<0>") + (2 * VT("/B<1>")) + (4 * VT("/B<2>")) + (8 * VT("/B<3>"))) / 0.8))
  Output err = abs((Pint - ABint))
  Output errw = abs((((VT("/P<0>") + (2 * VT("/P<1>")) + (4 * VT("/P<2>")) + (8 * VT("/P<3>")) + (16 * VT("/P<4>")) + (32 * VT("/P<5>")) + (64 * VT("/P<6>")) + (128 * VT("/P<7>"))) / VAR("vdd")) - (((VT("/A<0>") + (2 * VT("/A<1>")) + (4 * VT("/A<2>")) + (8 * VT("/A<3>"))) / VAR("vdd")) * ((VT("/B<0>") + (2 * VT("/B<1>")) + (4 * VT("/B<2>")) + (8 * VT("/B<3>"))) / VAR("vdd")))))
  Output errS = sample(abs((((VT("/P<0>") + (2 * VT("/P<1>")) + (4 * VT("/P<2>")) + (8 * VT("/P<3>")) + (16 * VT("/P<4>")) + (32 * VT("/P<5>")) + (64 * VT("/P<6>")) + (128 * VT("/P<7>"))) / VAR("vdd")) - (((VT("/A<0>") + (2 * VT("/A<1>")) + (4 * VT("/A<2>")) + (8 * VT("/A<3>"))) / VAR("vdd")) * ((VT("/B<0>") + (2 * VT("/B<1>")) + (4 * VT("/B<2>")) + (8 * VT("/B<3>"))) / VAR("vdd"))))) (0.95 * VAR("tv")) (255.95 * VAR("tv")) "linear" VAR("tv"))
  Output errmax = ymax(sample(abs((((VT("/P<0>") + (2 * VT("/P<1>")) + (4 * VT("/P<2>")) + (8 * VT("/P<3>")) + (16 * VT("/P<4>")) + (32 * VT("/P<5>")) + (64 * VT("/P<6>")) + (128 * VT("/P<7>"))) / VAR("vdd")) - (((VT("/A<0>") + (2 * VT("/A<1>")) + (4 * VT("/A<2>")) + (8 * VT("/A<3>"))) / VAR("vdd")) * ((VT("/B<0>") + (2 * VT("/B<1>")) + (4 * VT("/B<2>")) + (8 * VT("/B<3>"))) / VAR("vdd"))))) (0.95 * VAR("tv")) (255.95 * VAR("tv")) "linear" VAR("tv")))
  Output tworst = xmax(sample(abs((((VT("/P<0>") + (2 * VT("/P<1>")) + (4 * VT("/P<2>")) + (8 * VT("/P<3>")) + (16 * VT("/P<4>")) + (32 * VT("/P<5>")) + (64 * VT("/P<6>")) + (128 * VT("/P<7>"))) / VAR("vdd")) - (((VT("/A<0>") + (2 * VT("/A<1>")) + (4 * VT("/A<2>")) + (8 * VT("/A<3>"))) / VAR("vdd")) * ((VT("/B<0>") + (2 * VT("/B<1>")) + (4 * VT("/B<2>")) + (8 * VT("/B<3>"))) / VAR("vdd"))))) (0.95 * VAR("tv")) (255.95 * VAR("tv")) "linear" VAR("tv")) 1)
  Signals: /P<7>, /A<3:0>, /B<3:0>, /P<7:0>
Run mode: Single Run, Sweeps and Corners
Specs:
  proj1_lib_tb_multiplier4b_1 / errmax: < 0.5
  proj1_lib_tb_multiplier4b_1 / tworst: < (256 * tv)
Setup values for test proj1_lib_tb_multiplier4b_1: tv = 1n 1.1n 1.2n 1.3n 1.4n 1.5n
