ADE simulation setup
Run mode: Single Run, Sweeps and Corners
Tests:
  proj1_lib_tb_multiplier4b_1: proj1_lib/tb_multiplier4b/schematic, simulator spectre
    Variables: vdd = 0.8; tv = 1n 1.1n 1.2n 1.3n 1.4n 1.5n
    Outputs: u; errmax_old; Pint; err; ABint; errw; errS; errmax; tworst
Specs:
  proj1_lib_tb_multiplier4b_1 / errmax: < 0.5
  proj1_lib_tb_multiplier4b_1 / tworst: < (256 * tv)
