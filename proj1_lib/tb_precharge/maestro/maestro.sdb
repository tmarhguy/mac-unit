ADE simulation setup
Run mode: Single Run, Sweeps and Corners
Tests:
  proj1_lib_tb_precharge_1: proj1_lib/tb_precharge/schematic, simulator spectre
    Variables: CBL = 3.5f
    Outputs: eq_error; t_precharge; blb_min; bl_peak; bl_final
