ADE simulation setup
Test proj1_lib_tb_precharge_1: proj1_lib/tb_precharge/schematic, simulator spectre
  Models: /vast/projects/radway/cad-tools/pdks/gpdk018/cds_ff_mpt/../models/spectre/cds_ff_mpt.scs[tt]
  Variables: CBL = 3.5f
  Temperature: 27
  Analysis tran: stop=2n errpreset=moderate
  Output eq_error = abs((value(VT("/BL") 1.2e-09) - value(VT("/BLB") 1.2e-09)))
  Output t_precharge = delay(?wf1 VT("/PRE_B") ?value1 0.4 ?edge1 "falling" ?nth1 1 ?td1 0 ?wf2 VT("/BL") ?value2 0.792 ?edge2 "rising" ?nth2 1 ?td2 0)
  Output blb_min = ymin(clip(VT("/BLB") 2e-10 1.2e-09))
  Output bl_peak = ymax(VT("/BL"))
  Output bl_final = value(VT("/BL") 1.2e-09)
  Signals: /PRE_B, /BLB, /BL
Run mode: Single Run, Sweeps and Corners
