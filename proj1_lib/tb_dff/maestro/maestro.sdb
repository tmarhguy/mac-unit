ADE simulation setup
Run mode: Single Run, Sweeps and Corners
Tests:
  proj1_lib_tb_dff_1: proj1_lib/tb_dff/schematic, simulator spectre
