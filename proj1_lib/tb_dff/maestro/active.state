ADE simulation setup
Test proj1_lib_tb_dff_1: proj1_lib/tb_dff/schematic, simulator spectre
  Models: /vast/projects/radway/cad-tools/pdks/gpdk018/cds_ff_mpt/../models/spectre/cds_ff_mpt.scs[tt]
  Temperature: 27
  Analysis tran: stop=15n
  Signals: /Q
Run mode: Single Run, Sweeps and Corners
