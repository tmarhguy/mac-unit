ADE simulation setup
Test proj1_lib_tb_dff_1: proj1_lib/tb_dff/schematic, simulator spectre
  Models: /vast/projects/radway/cad-tools/pdks/gpdk018/cds_ff_mpt/../models/spectre/cds_ff_mpt.scs[tt]
  Temperature: 27
  Files: vectors /vast/projects/radway/ese-5700-fall/tmarhguy/project_1/stimuli/dff_energy_toggle.vec
  Analysis tran: stop=100n
  Signals: /Q, /CLK, /D, /VDD
Run mode: Single Run, Sweeps and Corners
