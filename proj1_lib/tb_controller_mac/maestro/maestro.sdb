ADE simulation setup
Run mode: Single Run, Sweeps and Corners
Tests:
  proj1_lib_tb_controller_mac_1: proj1_lib/tb_controller_mac/schematic, simulator spectre
    Variables: vdd = 0.8
