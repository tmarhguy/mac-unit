ADE simulation setup
Test proj1_lib_tb_controller_mac_1: proj1_lib/tb_controller_mac/schematic, simulator spectre
  Models: /vast/projects/radway/cad-tools/pdks/gpdk018/cds_ff_mpt/../models/spectre/cds_ff_mpt.scs[tt]
  Variables: vdd = 0.8
  Temperature: 27
  Files: vectors /vast/home/v/vwanjohi/simulation/stimuli/controller.vec
  Analysis tran: stop=61n errpreset=conservative
  Signals: /CLK, /RST, /RUN, /DONE, /ACC_EN, /COUNT<3>, /COUNT<2>, /COUNT<1>, /COUNT<0>
Run mode: Single Run, Sweeps and Corners
