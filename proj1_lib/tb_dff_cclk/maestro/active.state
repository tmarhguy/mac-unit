ADE simulation setup
Test proj1_lib_tb_dff_cclk_1: proj1_lib/tb_dff_cclk/schematic, simulator spectre
  Models: /vast/projects/radway/cad-tools/pdks/gpdk018/cds_ff_mpt/../models/spectre/cds_ff_mpt.scs[tt]
  Temperature: 27
  Analysis tran: stop=20n
  Signals: /CLK
Run mode: Single Run, Sweeps and Corners
