ADE simulation setup
Run mode: Single Run, Sweeps and Corners
Tests:
  proj1_lib_tb_read_path_vm_1: proj1_lib/tb_read_path_vm/schematic, simulator spectre
    Variables: vin = 0
    Outputs: vm
