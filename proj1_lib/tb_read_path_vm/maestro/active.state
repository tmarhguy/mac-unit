ADE simulation setup
Test proj1_lib_tb_read_path_vm_1: proj1_lib/tb_read_path_vm/schematic, simulator spectre
  Models: /vast/projects/radway/cad-tools/pdks/gpdk018/cds_ff_mpt/../models/spectre/cds_ff_mpt.scs[tt]
  Variables: vin = 0
  Temperature: 27
  Analysis dc: sweep vin start=0 stop=0.8 step=1m (saves the operating point)
  Output vm = cross((VS("/RD") - VS("/BLB")) 0 1 "falling")
  Signals: /RD
Run mode: Single Run, Sweeps and Corners
