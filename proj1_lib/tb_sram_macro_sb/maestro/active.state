ADE simulation setup
Test proj1_lib_tb_sram_macro_1: proj1_lib/tb_sram_macro/schematic, simulator spectre
  Models: /vast/projects/radway/cad-tools/pdks/gpdk018/cds_ff_mpt/../models/spectre/cds_ff_mpt.scs[tt]
  Variables: cbw = 0.62f; tclk = 0.7n 0.69n 0.68n 0.67n 0.66n 0.65n 0.6n
  Temperature: 27
  Analysis tran: stop=66n errpreset=moderate
  Output err1 = ymax(clip((VT("/M") * (abs((VT("/DOUT<0>") - VT("/E"))) + abs((VT("/DOUT<1>") - (0.8 - VT("/E")))) + abs((VT("/DOUT<2>") - VT("/E"))) + abs((VT("/DOUT<3>") - (0.8 - VT("/E")))))) (17 * VAR("tclk")) (33 * VAR("tclk")))) (unticked)
  Output err2 = ymax(clip((VT("/M") * (abs((VT("/DOUT<0>") - (0.8 - VT("/E")))) + abs((VT("/DOUT<1>") - VT("/E"))) + abs((VT("/DOUT<2>") - (0.8 - VT("/E")))) + abs((VT("/DOUT<3>") - VT("/E"))))) (49 * VAR("tclk")) (65 * VAR("tclk")))) (unticked)
  Output t_acc_f = (cross(VT("/DOUT<1>") 0.4 1 "falling") - cross(VT("/CLK") 0.4 17 "rising")) (unticked)
  Output t_acc_r = (cross(VT("/DOUT<1>") 0.4 1 "rising") - cross(VT("/CLK") 0.4 18 "rising")) (unticked)
  Output write_power = (0.8 * average(clip(IT("/I0/VDD") (32.5 * VAR("tclk")) (48.5 * VAR("tclk")))))
  Output read_power = (0.8 * average(clip(IT("/I0/VDD") (16.5 * VAR("tclk")) (32.5 * VAR("tclk")))))
  Signals: /CLK, /WE, /ADDR<3>, /ADDR<2>, /ADDR<1>, /ADDR<0>, /DIN<3>, /DIN<2>, /DIN<1>, /DIN<0>, /DOUT<3>, /DOUT<2>, /DOUT<1>, /DOUT<0>, /M, /E, /I0/VDD (terminal)
Test proj1_lib_tb_sram_macro_sb_1: proj1_lib/tb_sram_macro_sb/schematic, simulator spectre
  Models: /vast/projects/radway/cad-tools/pdks/gpdk018/cds_ff_mpt/../models/spectre/cds_ff_mpt.scs[tt]
  Variables: cbw = 0.62f; tclk = 0.69n
  Temperature: 27
  Analysis tran: stop=66n
  Output standby_power = (0.8 * average(clip(IT("/I0/VDD") 5e-08 6.6e-08)))
  Signals: /I0/VDD (terminal), /I0/ADDR<0>   (terminal), /DIN<0>, /CLK
