ADE simulation setup
Test proj1_lib_tb_write_driver_1: proj1_lib/tb_write_driver/schematic, simulator spectre
  Models: /vast/projects/radway/cad-tools/pdks/gpdk018/cds_ff_mpt/../models/spectre/cds_ff_mpt.scs[tt]
  Variables: CBL = 3.5f; pw_w1 = 0.3n
  Temperature: 27
  Analysis tran: stop=3n errpreset=moderate
  Output t_wr0 = (cross(clip((VT("/Q") - VT("/QB")) 1.3e-09 2e-09) 0 1 "falling") - cross(clip(VT("/WL") 1.3e-09 2e-09) 0.4 1 "rising"))
  Output t_wr1 = (cross(clip((VT("/Q") - VT("/QB")) 2.3e-09 3e-09) 0 1 "rising") - cross(clip(VT("/WL") 2.3e-09 3e-09) 0.4 1 "rising"))
  Output bl_low = ymin(clip(VT("/BL") 1.3e-09 2e-09))
  Output q_wr0 = value(VT("/Q") 1.95e-09)
  Output q_wr1 = value(VT("/Q") 2.95e-09)
  Output q_min_wr0 = ymin(clip(VT("/Q") 1.4e-09 1.75e-09))
  Output t_wr0_sw = (max(cross(clip(VT("/Q") 1.3e-09 2e-09) 0.335 1 "falling") cross(clip(VT("/QB") 1.3e-09 2e-09) 0.335 1 "rising")) - cross(clip(VT("/WL") 1.3e-09 2e-09) 0.4 1 "rising"))
  Output blb_min = ymin(clip(VT("/BLB") 1.4e-09 1.71e-09))
  Signals: /WL, /WR_EN, /PRE_B, /BL, /BLB, /Q, /QB
Run mode: Single Run, Sweeps and Corners
Global variables:
  pw_w1 = 40p 60p 80p 100p 120p 150p
  CBL = 3.5f 4.2f
Specs:
  proj1_lib_tb_write_driver_1 / nil: < 0.08
  proj1_lib_tb_write_driver_1 / q_wr1: > 0.72
  proj1_lib_tb_write_driver_1 / q_wr0: < 0.08
