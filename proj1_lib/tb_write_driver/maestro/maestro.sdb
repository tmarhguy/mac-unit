ADE simulation setup
Run mode: Single Run, Sweeps and Corners
Tests:
  proj1_lib_tb_write_driver_1: proj1_lib/tb_write_driver/schematic, simulator spectre
    Variables: CBL = 3.5f; pw_w1 = 0.3n
    Outputs: nil; t_wr1; bl_low; q_wr0; q_wr1; t_wr0; q_min_wr0; t_wr0_sw; blb_min
Global variables:
  pw_w1 = 40p 60p 80p 100p 120p 150p
  CBL = 3.5f 4.2f
Specs:
  proj1_lib_tb_write_driver_1 / nil: < 0.08
  proj1_lib_tb_write_driver_1 / q_wr1: > 0.72
  proj1_lib_tb_write_driver_1 / q_wr0: < 0.08
